** sch_path: /foss/designs/sero/simulations/tb/freq_v_length.sch
**.subckt freq_v_length osc_out
*.opin osc_out
x1 VDD osc_out 0 sero
V1 VDD 0 1.2
**** begin user architecture code

.lib cornerMOSlv.lib mos_ss

.param length=0.13u
.control
  save all
  let l_start = 0.13e-6
  let l_stop  = 0.40e-6
  let l_step  = 0.03e-6
  let n_pts   = 10
  let lengths = vector(n_pts)
  let freqs   = vector(n_pts)
  let idx = 0

  while idx < n_pts
    let l_curr = l_start + idx * l_step
    alterparam length = $&l_curr
    reset

    let tstop_val = 8e-9 * (l_curr / 0.13e-6)
    tran 1p $&tstop_val uic

    meas tran t1 when v(osc_out)=0.6 rise=4
    meas tran t2 when v(osc_out)=0.6 rise=5

    let freqs[idx]   = 1 / (t2 - t1)
    let lengths[idx] = l_curr

    let idx = idx + 1
  end

  set curplot = control
  write freq_v_length.raw freqs lengths
.endc

**** end user architecture code
**.ends

* expanding   symbol:  /foss/designs/sero/design/symbol/sero.sym # of pins=3
** sym_path: /foss/designs/sero/design/symbol/sero.sym
** sch_path: /foss/designs/sero/design/schematics/sero.sch
.subckt sero vdd osc_out gnd
*.opin osc_out
*.iopin vdd
*.iopin gnd
x6 vdd osc_out net1 gnd inverter
x1 vdd net1 net2 gnd inverter
x2 vdd net2 net3 gnd inverter
x3 vdd net3 net4 gnd inverter
x4 vdd net4 osc_out gnd inverter
.ends

* expanding   symbol:  /foss/designs/sero/design/symbol/inverter.sym # of pins=4
** sym_path: /foss/designs/sero/design/symbol/inverter.sym
** sch_path: /foss/designs/sero/design/schematics/inverter.sch
.subckt inverter vdd vin vout gnd
*.iopin vdd
*.iopin gnd
*.ipin vin
*.opin vout
XM2 vout vin gnd gnd sg13_lv_nmos w=0.13u l={length} ng=1 m=1 mm_ok=1
XM1 vout vin vdd vdd sg13_lv_pmos w=0.225u l={length} ng=1 m=1 mm_ok=1
.ends

.GLOBAL VDD
.end
