* Extracted by KLayout with SG13G2 LVS runset on : 19/07/2026 10:40

.SUBCKT sero_lyt
X$1 gnd vdd osc_out \$I16 inverter
X$2 gnd vdd \$I16 \$I15 inverter
X$3 gnd vdd \$I15 \$6 inverter
X$4 gnd vdd \$6 \$10 inverter
X$5 gnd vdd \$10 osc_out inverter
.ENDS sero_lyt

.SUBCKT inverter gnd vdd vout vin
X$1 vdd vout vin vdd pmos
X$2 gnd vout gnd vin nmos
.ENDS inverter

.SUBCKT nmos \$1 \$2 \$3 \$5
M$1 \$1 \$5 \$2 \$3 sg13_lv_nmos L=0.13u W=0.15u AS=0.1005p AD=0.1005p PS=1.34u
+ PD=1.34u rfmode=0
.ENDS nmos

.SUBCKT pmos \$1 \$2 \$3 \$4
M$1 \$1 \$3 \$2 \$4 sg13_lv_pmos L=0.13u W=0.25u AS=0.1075p AD=0.1075p PS=1.34u
+ PD=1.34u rfmode=0
.ENDS pmos
